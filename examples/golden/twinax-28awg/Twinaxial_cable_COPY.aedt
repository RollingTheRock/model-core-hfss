# Ansys Electronics Desktop project, version 2025.2
project variables:
  $losstan = 0
materials:
  PE_foam1: permittivity=1.65 dielectric_loss_tangent=0.00045
  air: permittivity=1.0006 permeability=1.0000004
  aluminum: permeability=1.000021 conductivity=38000000
  silver: permeability=0.99998 conductivity=61000000
  vacuum: permittivity=1

design Twinaxial_cable_28AWG (HFSS, HFSS Hybrid Terminal Network, model units mil)
options: Calculate_Lossy_Dielectrics Save_Adaptive_support_files
variables:
  ModelLength = 2mil
  PlatingThickness = 1.524um
  SigRadius = 6.3mil
  Spacing = 37mil
  DrainOffset = 16mil
  DrainRadius = 5.63mil
  PERadius = 17.25mil
  RibWidth = 27mil
  D = sqrt((Spacing/2)^2+DrainOffset^2)
  theta0 = acos((PERadius-DrainRadius)/D)
  abc = 20deg
  theta1 = atan(DrainOffset/(Spacing/2))
geometry:
  S1 [silver] = cylinder(axis=Z, base_centre=(0mil, -Spacing/2, -ModelLength/2), radius=SigRadius, height=ModelLength)
  PE [PE_foam1] = cylinder(axis=Z, base_centre=(0mil, -Spacing/2, -ModelLength/2), radius=PERadius, height=ModelLength)
  drain [aluminum] = cylinder(axis=Z, base_centre=(DrainOffset, 0mil, -ModelLength/2), radius=DrainRadius, height=ModelLength)
  Foam_Rib = box(corner=(-RibWidth/2, -Spacing/2, -ModelLength/2), size=(RibWidth, Spacing, ModelLength))
  coordinate_system DrainCS = origin=(DrainOffset, 0mil, 0mil) x=(-DrainOffset, -Spacing/2, 0mil) y=(1mil, -1mil, 0mil)
  coordinate_system SignalCS = origin=(D, 0mil, 0mil) x=(1mil, 0mil, 0mil) y=(0mil, 1mil, 0mil) in DrainCS
  DrainSection = drain.section(plane=YZ) in DrainCS
  DrainSection.split(plane=ZX, keep=PositiveOnly) in DrainCS
  TeflonSection = PE.section(plane=YZ) in SignalCS
  TeflonSection.split(plane=ZX, keep=PositiveOnly) in SignalCS
  DrainSection.rotate(axis=Z, angle=90deg-theta0) in DrainCS
  TeflonSection.rotate(axis=Z, angle=90deg-theta0) in SignalCS
  DrainSection.connect(TeflonSection)
  coordinate_system TeflonCS = origin=(0mil, -Spacing/2, -1mil) x=(1mil, 0mil, 0mil) y=(0mil, 1mil, 0mil)
  Air [air] = PE.section(plane=ZX) in TeflonCS
  DrainSection_1 = DrainSection.duplicate_mirror(point=(0mil, 0mil, 0mil), normal=(0mil, 1mil, 0mil))
  PE_1 = PE.duplicate_mirror(point=(0mil, 0mil, 0mil), normal=(0mil, 1mil, 0mil))
  S2 [silver] = S1.duplicate_mirror(point=(0mil, 0mil, 0mil), normal=(0mil, 1mil, 0mil))
  AirSection_1 = Air.duplicate_mirror(point=(0mil, 0mil, 0mil), normal=(0mil, 1mil, 0mil))
  PE.unite(Foam_Rib, PE_1)
  Air.connect(AirSection_1)
  PE1 = cylinder(axis=Z, base_centre=(0mil, -Spacing/2, -ModelLength/2), radius=PERadius, height=ModelLength)
  PE_2 = PE1.duplicate_mirror(point=(0mil, 0mil, 0mil), normal=(0mil, 1mil, 0mil))
  Foam_Rib1 = box(corner=(-RibWidth/2, -Spacing/2, -ModelLength/2), size=(RibWidth, Spacing, ModelLength))
  PE1.unite(Foam_Rib1, PE_2)
  drain1 = cylinder(axis=Z, base_centre=(DrainOffset, 0mil, -ModelLength/2), radius=DrainRadius, height=ModelLength)
  Air.unite(drain1, DrainSection, DrainSection_1, PE1)
  drain_1 = drain.copy()
  PE.subtract(drain_1)
boundaries and excitations:
  Shield: Finite Conductivity Faces=Air.face(at (-1.8766, -35.6476, 0), at (-1.8766, 35.6476, 0), at (19.1692, 11.7243, 0), at (21.63, 0, 0), at (19.1692, -11.7243, 0), at (-17.25, 0, 0)) UseMaterial Material=aluminum Thickness=2mm
  1a: Terminal port=1 Faces=S1.face(-z end) TerminalResistance=50ohm
  1b: Terminal port=1 Faces=S2.face(at (0, 18.5, -1)) TerminalResistance=50ohm
  2a: Terminal port=2 Faces=S1.face(+z end) TerminalResistance=50ohm
  2b: Terminal port=2 Faces=S2.face(at (0, 18.5, 1)) TerminalResistance=50ohm
  1: Wave Port Faces=Air.face(at (2.30664, 0, -1)) WavePortType=Terminal NumModes=2 DeembedDist=-(1in-ModelLength)/2
  2: Wave Port Faces=Air.face(at (2.30664, 0, 1)) WavePortType=Terminal NumModes=2 DeembedDist=-(1in-ModelLength)/2
setups:
  3GHz: HfssDriven Frequency=3GHz MaxDeltaS=0.02 MaximumPasses=3 MinimumPasses=3 MinimumConvergedPasses=1 PercentRefinement=30 BasisOrder=1 MaxTetIncrease=1000000 PortAccuracy=0.1 DrivenSolverType="Direct Solver" IESolverType=ACA
    sweep DC_10GHz: 0GHz to 10GHz step 50MHz; Type=Interpolating InterpTolerance=0.5 InterpMaxSolns=50 MinSolvedFreq=0.01GHz PassivityErrorTolerance=0.0001
source amplitudes:
  1:1: 1W 0deg
  1:2, 2:1, 2:2: 0W 0deg
output variables:
  AVGDZ0 = avg(DeltaDZ0)
  DeltaDZ0 = abs(DiffZo1-DiffZo2)
  DiffZo1 = mag(Zot(D,D))
  DiffZo2 = mag(Zot(2_D,2_D))
reports:
  Terminal S Parameter Plot 1: dB(St(D1,D1)), dB(St(D2,D1)) vs Freq on 3GHz : DC_10GHz [Spacing=all]
  Terminal Port Zo Plot 1: mag(Zot(D1,D1)), mag(Zot(D2,D2)) vs Freq on 3GHz : DC_10GHz [Spacing=all]
  Terminal TDR Impedance Plot 1: TDRZt(D1), TDRZt(D2) vs Time on 3GHz : DC_10GHz [Spacing=all]
